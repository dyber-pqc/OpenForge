.subckt inverter in out vdd vss
M1 out in vss vss nmos_rvt w=0.42 l=0.15
M2 out in vdd vdd nmos_rvt w=0.84 l=0.15
.ends inverter
